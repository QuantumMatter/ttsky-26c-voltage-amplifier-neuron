* NGSPICE file created from inv.ext - technology: sky130A

.subckt sky130_fd_pr__nfet_01v8_FGWQMQ B D S G
X0 S G D B sky130_fd_pr__nfet_01v8 ad=0.29 pd=2.58 as=0.29 ps=2.58 w=1 l=0.5
.ends

.subckt sky130_fd_pr__pfet_01v8_lvt_7M33HH B D S G
X0 S G D B sky130_fd_pr__pfet_01v8_lvt ad=0.58 pd=4.58 as=0.58 ps=4.58 w=2 l=0.5
.ends

.subckt inv VDD IN OUT VSS
XXM1 VSS OUT VSS IN sky130_fd_pr__nfet_01v8_FGWQMQ
XXM2 VDD VDD OUT IN sky130_fd_pr__pfet_01v8_lvt_7M33HH
.ends
