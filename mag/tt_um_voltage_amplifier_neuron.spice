* NGSPICE file created from tt_um_voltage_amplifier_neuron.ext - technology: sky130A

.subckt sky130_fd_pr__res_xhigh_po_0p35_TR4WTB B R1 R2
X0 R1 R2 B sky130_fd_pr__res_xhigh_po_0p35 l=10
.ends

.subckt sky130_fd_pr__res_xhigh_po_0p35_JXEFPG B R1 R2
X0 R1 R2 B sky130_fd_pr__res_xhigh_po_0p35 l=6.36
.ends

.subckt sky130_fd_pr__nfet_01v8_PCYQPL B D S G
X0 S G D B sky130_fd_pr__nfet_01v8 ad=0.29 pd=2.58 as=0.29 ps=2.58 w=1 l=4
.ends

.subckt sky130_fd_pr__nfet_01v8_WZVWL4 B D0 S0 G0 D1 S1 G1 D2 S2 G2 D3 S3 G3
X0 S2 G2 D2 B sky130_fd_pr__nfet_01v8 ad=0.29 pd=2.58 as=0.29 ps=2.58 w=1 l=4
X1 S0 G0 D0 B sky130_fd_pr__nfet_01v8 ad=0.29 pd=2.58 as=0.29 ps=2.58 w=1 l=4
X2 S3 G3 D3 B sky130_fd_pr__nfet_01v8 ad=0.29 pd=2.58 as=0.29 ps=2.58 w=1 l=4
X3 S1 G1 D1 B sky130_fd_pr__nfet_01v8 ad=0.29 pd=2.58 as=0.29 ps=2.58 w=1 l=4
.ends

.subckt sky130_fd_pr__nfet_01v8_BVB23V B D S G
X0 S G D B sky130_fd_pr__nfet_01v8 ad=0.58 pd=4.58 as=0.58 ps=4.58 w=2 l=4
.ends

.subckt sky130_fd_pr__pfet_01v8_lvt_Y5YEVR B D S G
X0 S G D B sky130_fd_pr__pfet_01v8_lvt ad=0.58 pd=4.58 as=0.58 ps=4.58 w=2 l=4
.ends

.subckt sky130_fd_pr__nfet_01v8_FGWQMQ B D S G
X0 S G D B sky130_fd_pr__nfet_01v8 ad=0.29 pd=2.58 as=0.29 ps=2.58 w=1 l=0.5
.ends

.subckt sky130_fd_pr__pfet_01v8_lvt_7M33HH B D S G
X0 S G D B sky130_fd_pr__pfet_01v8_lvt ad=0.58 pd=4.58 as=0.58 ps=4.58 w=2 l=0.5
.ends

.subckt sky130_fd_pr__pfet_01v8_8SGQ8J B D S G
X0 S G D B sky130_fd_pr__pfet_01v8 ad=0.29 pd=2.58 as=0.29 ps=2.58 w=1 l=4
.ends

.subckt sky130_fd_pr__pfet_01v8_9ZQHCF B D0 S0 G0 D1 S1 G1
X0 S1 G1 D1 B sky130_fd_pr__pfet_01v8 ad=0.725 pd=5.58 as=0.725 ps=5.58 w=2.5 l=4
X1 S0 G0 D0 B sky130_fd_pr__pfet_01v8 ad=0.725 pd=5.58 as=0.725 ps=5.58 w=2.5 l=4
.ends

.subckt sky130_fd_pr__pfet_01v8_lvt_GCEZRS B D S G
X0 S G D B sky130_fd_pr__pfet_01v8_lvt ad=11.6 pd=80.58 as=11.6 ps=80.58 w=40 l=0.5
.ends

.subckt sky130_fd_pr__cap_mim_m3_1_4SQMGA C2 C1
X0 C1 C2 sky130_fd_pr__cap_mim_m3_1 l=22.63 w=22.63
.ends

.subckt sky130_fd_pr__cap_mim_m3_1_3EYAHJ C2 C1
X0 C1 C2 sky130_fd_pr__cap_mim_m3_1 l=24.75 w=24.75
.ends

.subckt sky130_fd_pr__pfet_01v8_8LLZS6 B D0 S0 G0 D1 S1 G1
X0 S0 G0 D0 B sky130_fd_pr__pfet_01v8 ad=2.9 pd=20.58 as=2.9 ps=20.58 w=10 l=0.75
X1 S1 G1 D1 B sky130_fd_pr__pfet_01v8 ad=2.9 pd=20.58 as=2.9 ps=20.58 w=10 l=0.75
.ends

.subckt vamp_if_neuron V_MEM_BUF rst_n IN1 IN2 IN3 IN4 IN5 XR4/R1 XM3/G XM6/G XM9/G
+ XM7/G VCC VSS XM8/G1 XM2/G3
XXR3 VSS XR4/R1 VCC sky130_fd_pr__res_xhigh_po_0p35_TR4WTB
XXR4 VSS XR4/R1 VSS sky130_fd_pr__res_xhigh_po_0p35_JXEFPG
XXM1 VSS XM9/G XM1/S XM6/S sky130_fd_pr__nfet_01v8_PCYQPL
XXM2 VSS XM1/S VSS XM2/G3 XM1/S VSS XM2/G3 XM1/S VSS XM2/G3 XM1/S VSS XM2/G3 sky130_fd_pr__nfet_01v8_WZVWL4
XXM3 VSS XM5/S VSS XM3/G sky130_fd_pr__nfet_01v8_BVB23V
XXM4 VCC XM7/S XM9/G XM6/G sky130_fd_pr__pfet_01v8_lvt_Y5YEVR
XXM5 VSS XM6/S XM5/S XM6/G sky130_fd_pr__nfet_01v8_FGWQMQ
XXM6 VCC XM6/D XM6/S XM6/G sky130_fd_pr__pfet_01v8_lvt_7M33HH
XXM7 VCC VCC XM7/S XM7/G sky130_fd_pr__pfet_01v8_8SGQ8J
XXM8 VCC VCC XM6/D XM8/G1 VCC XM6/D XM8/G1 sky130_fd_pr__pfet_01v8_9ZQHCF
XXM9 VCC V_MEM_BUF VSS XM9/G sky130_fd_pr__pfet_01v8_lvt_GCEZRS
XXC1 XM9/G VSS sky130_fd_pr__cap_mim_m3_1_4SQMGA
XXC2 XM6/S VSS sky130_fd_pr__cap_mim_m3_1_3EYAHJ
XXC3 XM9/G VSS sky130_fd_pr__cap_mim_m3_1_4SQMGA
XXC4 XM6/S VSS sky130_fd_pr__cap_mim_m3_1_3EYAHJ
XXM10 VCC V_MEM_BUF VCC XM7/G V_MEM_BUF VCC XM7/G sky130_fd_pr__pfet_01v8_8LLZS6
XXM11 VSS XM9/G VSS XM3/G sky130_fd_pr__nfet_01v8_PCYQPL
.ends

.subckt sky130_fd_pr__nfet_01v8_XETRKN B D0 S0 G0 D1 S1 G1
X0 S0 G0 D0 B sky130_fd_pr__nfet_01v8 ad=0.29 pd=2.58 as=0.29 ps=2.58 w=1 l=1
X1 S1 G1 D1 B sky130_fd_pr__nfet_01v8 ad=0.29 pd=2.58 as=0.29 ps=2.58 w=1 l=1
.ends

.subckt ota VCC OUT - + VSS BIAS
XXM1 VSS XM4/G XM2/S + sky130_fd_pr__nfet_01v8_FGWQMQ
XXM2 VSS OUT XM2/S - sky130_fd_pr__nfet_01v8_FGWQMQ
XXM3 VCC VCC XM4/G XM4/G sky130_fd_pr__pfet_01v8_lvt_7M33HH
XXM4 VCC VCC OUT XM4/G sky130_fd_pr__pfet_01v8_lvt_7M33HH
XXM5 VSS XM2/S VSS BIAS XM2/S VSS BIAS sky130_fd_pr__nfet_01v8_XETRKN
.ends

.subckt inv VDD IN OUT VSS
XXM1 VSS OUT VSS IN sky130_fd_pr__nfet_01v8_FGWQMQ
XXM2 VDD VDD OUT IN sky130_fd_pr__pfet_01v8_lvt_7M33HH
.ends

.subckt sky130_fd_pr__res_xhigh_po_0p35_872VHY B R1 R2
X0 R1 R2 B sky130_fd_pr__res_xhigh_po_0p35 l=135.5
.ends

.subckt sky130_fd_pr__nfet_01v8_XV5MNW B D S G
X0 S G D B sky130_fd_pr__nfet_01v8 ad=2.32 pd=16.58 as=2.32 ps=16.58 w=8 l=4
.ends

.subckt bmr_10n VCC VBP rst_n VBN VSS
XXR1 VSS XR2/R1 XM3/S sky130_fd_pr__res_xhigh_po_0p35_872VHY
XXR2 VSS XR2/R1 XR3/R2 sky130_fd_pr__res_xhigh_po_0p35_872VHY
XXR3 VSS XR4/R1 XR3/R2 sky130_fd_pr__res_xhigh_po_0p35_872VHY
XXR5 VSS XR6/R1 XR5/R2 sky130_fd_pr__res_xhigh_po_0p35_872VHY
XXR4 VSS XR4/R1 XR5/R2 sky130_fd_pr__res_xhigh_po_0p35_872VHY
XXR6 VSS XR6/R1 XR7/R2 sky130_fd_pr__res_xhigh_po_0p35_872VHY
XXM1 VCC VCC VBP VBP sky130_fd_pr__pfet_01v8_8SGQ8J
XXR7 VSS XR8/R1 XR7/R2 sky130_fd_pr__res_xhigh_po_0p35_872VHY
XXM2 VCC VCC VBN VBP sky130_fd_pr__pfet_01v8_8SGQ8J
XXR8 VSS XR8/R1 VSS sky130_fd_pr__res_xhigh_po_0p35_872VHY
XXM3 VSS VBP XM3/S VBN sky130_fd_pr__nfet_01v8_XV5MNW
XXM4 VSS VBN VSS VBN sky130_fd_pr__nfet_01v8_PCYQPL
XXM5 VCC VCC VBN rst_n sky130_fd_pr__pfet_01v8_8SGQ8J
.ends

.subckt sky130_fd_pr__nfet_01v8_YM6BDQ B D0 S0 G0 D1 S1 G1 D2 S2 G2 D3 S3 G3 D4 S4
+ G4 D5 S5 G5 D6 S6 G6 D7 S7 G7 D8 S8 G8 D9 S9 G9
X0 S8 G8 D8 B sky130_fd_pr__nfet_01v8 ad=0.29 pd=2.58 as=0.29 ps=2.58 w=1 l=4
X1 S0 G0 D0 B sky130_fd_pr__nfet_01v8 ad=0.29 pd=2.58 as=0.29 ps=2.58 w=1 l=4
X2 S7 G7 D7 B sky130_fd_pr__nfet_01v8 ad=0.29 pd=2.58 as=0.29 ps=2.58 w=1 l=4
X3 S5 G5 D5 B sky130_fd_pr__nfet_01v8 ad=0.29 pd=2.58 as=0.29 ps=2.58 w=1 l=4
X4 S2 G2 D2 B sky130_fd_pr__nfet_01v8 ad=0.29 pd=2.58 as=0.29 ps=2.58 w=1 l=4
X5 S3 G3 D3 B sky130_fd_pr__nfet_01v8 ad=0.29 pd=2.58 as=0.29 ps=2.58 w=1 l=4
X6 S9 G9 D9 B sky130_fd_pr__nfet_01v8 ad=0.29 pd=2.58 as=0.29 ps=2.58 w=1 l=4
X7 S1 G1 D1 B sky130_fd_pr__nfet_01v8 ad=0.29 pd=2.58 as=0.29 ps=2.58 w=1 l=4
X8 S6 G6 D6 B sky130_fd_pr__nfet_01v8 ad=0.29 pd=2.58 as=0.29 ps=2.58 w=1 l=4
X9 S4 G4 D4 B sky130_fd_pr__nfet_01v8 ad=0.29 pd=2.58 as=0.29 ps=2.58 w=1 l=4
.ends

.subckt bmr VBP_REF10N VBP_REF1N VBN_REF1N rst_n VBN_REF10N VCC VSS
Xx1 VCC VBP_REF10N rst_n VBN_REF10N VSS bmr_10n
XXM1 VCC VCC VBN_REF1N VBP_REF10N sky130_fd_pr__pfet_01v8_8SGQ8J
XXM2 VSS VBN_REF1N VSS VBN_REF1N VBN_REF1N VSS VBN_REF1N VBN_REF1N VSS VBN_REF1N VBN_REF1N
+ VSS VBN_REF1N VBN_REF1N VSS VBN_REF1N VBN_REF1N VSS VBN_REF1N VBN_REF1N VSS VBN_REF1N
+ VBN_REF1N VSS VBN_REF1N VBN_REF1N VSS VBN_REF1N VBN_REF1N VSS VBN_REF1N sky130_fd_pr__nfet_01v8_YM6BDQ
XXM3 VSS VBP_REF1N VSS VBN_REF1N sky130_fd_pr__nfet_01v8_PCYQPL
XXM4 VCC VCC VBP_REF1N VBP_REF1N sky130_fd_pr__pfet_01v8_8SGQ8J
.ends

.subckt sky130_fd_pr__pfet_01v8_CQGWXL B D S G
X0 S G D B sky130_fd_pr__pfet_01v8 ad=0.145 pd=1.58 as=0.145 ps=1.58 w=0.5 l=8
.ends

.subckt sky130_fd_pr__pfet_01v8_5ZWTQG B D0 S0 G0 D1 S1 G1
X0 S1 G1 D1 B sky130_fd_pr__pfet_01v8 ad=0.29 pd=2.58 as=0.29 ps=2.58 w=1 l=4
X1 S0 G0 D0 B sky130_fd_pr__pfet_01v8 ad=0.29 pd=2.58 as=0.29 ps=2.58 w=1 l=4
.ends

.subckt sky130_fd_pr__pfet_01v8_E3M74M B D S G
X0 S G D B sky130_fd_pr__pfet_01v8 ad=0.145 pd=1.58 as=0.145 ps=1.58 w=0.5 l=16
.ends

.subckt input_current_bank VCC IN1 IN2 IN3 IN4 IN5 VBP_REF1N V_STIM
XXM14 VCC VCC XM15/D VBP_REF1N sky130_fd_pr__pfet_01v8_CQGWXL
XXM13 VCC XM13/D V_STIM IN1 sky130_fd_pr__pfet_01v8_lvt_Y5YEVR
XXM15 VCC XM15/D V_STIM IN2 sky130_fd_pr__pfet_01v8_lvt_Y5YEVR
XXM16 VCC VCC XM17/D VBP_REF1N sky130_fd_pr__pfet_01v8_8SGQ8J
XXM17 VCC XM17/D V_STIM IN3 sky130_fd_pr__pfet_01v8_lvt_Y5YEVR
XXM18 VCC VCC XM19/D VBP_REF1N sky130_fd_pr__pfet_01v8_8SGQ8J
XXM19 VCC XM19/D V_STIM IN4 sky130_fd_pr__pfet_01v8_lvt_Y5YEVR
XXM20 VCC VCC XM21/D VBP_REF1N VCC XM21/D VBP_REF1N sky130_fd_pr__pfet_01v8_5ZWTQG
XX0.5 VCC VCC XM13/D VBP_REF1N sky130_fd_pr__pfet_01v8_E3M74M
XXM21 VCC XM21/D V_STIM IN5 sky130_fd_pr__pfet_01v8_lvt_Y5YEVR
.ends

.subckt tt_um_voltage_amplifier_neuron clk ena rst_n ua[0] ua[1] ua[2] ua[3] ua[4]
+ ua[5] ua[6] ua[7] ui_in[0] ui_in[1] ui_in[2] ui_in[3] ui_in[4] ui_in[5] ui_in[6]
+ ui_in[7] uio_in[0] uio_in[1] uio_in[2] uio_in[3] uio_in[4] uio_in[5] uio_in[6] uio_in[7]
+ uio_oe[0] uio_oe[1] uio_oe[2] uio_oe[3] uio_oe[4] uio_oe[5] uio_oe[6] uio_oe[7]
+ uio_out[0] uio_out[1] uio_out[2] uio_out[3] uio_out[4] uio_out[5] uio_out[6] uio_out[7]
+ uo_out[0] uo_out[1] uo_out[2] uo_out[3] uo_out[4] uo_out[5] uo_out[6] uo_out[7]
+ VDPWR VGND
Xvamp_if_neuron_0 ua[0] vamp_if_neuron_0/rst_n vamp_if_neuron_0/IN1 vamp_if_neuron_0/IN2
+ vamp_if_neuron_0/IN3 vamp_if_neuron_0/IN4 vamp_if_neuron_0/IN5 ota_0/- bmr_0/VBN_REF1N
+ inv_0/OUT ota_0/+ bmr_0/VBP_REF10N VDPWR VGND bmr_0/VBP_REF1N ota_0/BIAS vamp_if_neuron
Xota_0 VDPWR inv_0/IN ota_0/- ota_0/+ VGND ota_0/BIAS ota
Xinv_0 VDPWR inv_0/IN inv_0/OUT VGND inv
Xbmr_0 bmr_0/VBP_REF10N bmr_0/VBP_REF1N bmr_0/VBN_REF1N rst_n ota_0/BIAS VDPWR VGND
+ bmr
Xinput_current_bank_0 VDPWR ui_in[0] ui_in[1] ui_in[2] ui_in[3] ui_in[4] bmr_0/VBP_REF1N
+ ota_0/+ input_current_bank
.ends
