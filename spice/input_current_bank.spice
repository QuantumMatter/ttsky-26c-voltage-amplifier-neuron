** sch_path: /foss/designs/ttsky-26c-voltage-amplifier-neuron/schem/input_current_bank.sch
.subckt input_current_bank VCC V_STIM VBP_REF1N IN1 IN2 IN3 IN4 IN5
*.PININFO VCC:B V_STIM:B VBP_REF1N:I IN1:I IN2:I IN3:I IN4:I IN5:I
X0.5 net1 VBP_REF1N VCC VCC sky130_fd_pr__pfet_01v8 L=16 W=0.5 nf=1
XM13 V_STIM IN1 net1 VCC sky130_fd_pr__pfet_01v8_lvt L=4 W=2 nf=1
XM14 net2 VBP_REF1N VCC VCC sky130_fd_pr__pfet_01v8 L=8 W=0.5 nf=1
XM15 V_STIM IN2 net2 VCC sky130_fd_pr__pfet_01v8_lvt L=4 W=2 nf=1
XM16 net3 VBP_REF1N VCC VCC sky130_fd_pr__pfet_01v8 L=4 W=1 nf=1
XM17 V_STIM IN3 net3 VCC sky130_fd_pr__pfet_01v8_lvt L=4 W=2 nf=1
XM18 net4 VBP_REF1N VCC VCC sky130_fd_pr__pfet_01v8 L=4 W=1 nf=1
XM19 V_STIM IN4 net4 VCC sky130_fd_pr__pfet_01v8_lvt L=4 W=2 nf=1
XM20 net5 VBP_REF1N VCC VCC sky130_fd_pr__pfet_01v8 L=4 W=1 nf=1 m=2
XM21 V_STIM IN5 net5 VCC sky130_fd_pr__pfet_01v8_lvt L=4 W=2 nf=1
.ends
