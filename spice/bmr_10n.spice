** sch_path: /foss/designs/ttsky-26c-voltage-amplifier-neuron/schem/bias/bmr_10n.sch
.subckt bmr_10n VCC VBP VSS VBN rst_n
*.PININFO VCC:B VSS:B rst_n:I VBP:O VBN:O
XM1 VBP VBP VCC VCC sky130_fd_pr__pfet_01v8 L=4 W=1 nf=1
XM2 net3 VBP VCC VCC sky130_fd_pr__pfet_01v8 L=4 W=1 nf=1
XM3 net2 VBN net1 VSS sky130_fd_pr__nfet_01v8 L=4 W=8 nf=1
XM4 VBN VBN VSS VSS sky130_fd_pr__nfet_01v8 L=4 W=1 nf=1
XR1 net4 net1 VSS sky130_fd_pr__res_xhigh_po_0p35 L=135.5 mult=1
VSRIGHT VBP net2 0
.save i(vsright)
VSLEFT net3 VBN 0
.save i(vsleft)
XM5 VBN rst_n VCC VCC sky130_fd_pr__pfet_01v8 L=4 W=1 nf=1
XR2 net5 net4 VSS sky130_fd_pr__res_xhigh_po_0p35 L=135.5 mult=1
XR3 net6 net5 VSS sky130_fd_pr__res_xhigh_po_0p35 L=135.5 mult=1
XR4 net7 net6 VSS sky130_fd_pr__res_xhigh_po_0p35 L=135.5 mult=1
XR5 net8 net7 VSS sky130_fd_pr__res_xhigh_po_0p35 L=135.5 mult=1
XR6 net9 net8 VSS sky130_fd_pr__res_xhigh_po_0p35 L=135.5 mult=1
XR7 net10 net9 VSS sky130_fd_pr__res_xhigh_po_0p35 L=135.5 mult=1
XR8 VSS net10 VSS sky130_fd_pr__res_xhigh_po_0p35 L=135.5 mult=1
.ends
