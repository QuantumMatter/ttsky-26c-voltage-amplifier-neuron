** sch_path: /foss/designs/ttsky-26c-voltage-amplifier-neuron/schem/ota/ota.sch
.subckt ota VCC OUT VSS BIAS + -
*.PININFO BIAS:I +:I -:I OUT:O VCC:B VSS:B
XM1 VSRC + VBOT VSS sky130_fd_pr__nfet_01v8 L=0.5 W=1 nf=1
XM2 OUT - VBOT VSS sky130_fd_pr__nfet_01v8 L=0.5 W=1 nf=1
XM3 VSRC VSRC VCC VCC sky130_fd_pr__pfet_01v8_lvt L=0.5 W=2 nf=1
XM4 OUT VSRC VCC VCC sky130_fd_pr__pfet_01v8_lvt L=0.5 W=2 nf=1
XM5 VBOT BIAS VSS VSS sky130_fd_pr__nfet_01v8 L=1 W=1 nf=1 m=2
.ends
