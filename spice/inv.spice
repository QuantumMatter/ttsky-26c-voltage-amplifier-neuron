** sch_path: /foss/designs/ttsky-26c-voltage-amplifier-neuron/schem/inv/inv.sch
.subckt inv VDD IN OUT VSS
*.PININFO IN:I VDD:B VSS:B OUT:O
XM1 OUT IN VSS VSS sky130_fd_pr__nfet_01v8 L=0.5 W=1 nf=1
XM2 OUT IN VDD VDD sky130_fd_pr__pfet_01v8_lvt L=0.5 W=2 nf=1
.ends
